* Editable RC step response, tau = 1 kohm * 1 uF = 1 ms
V1 in 0 PULSE(0 5 0 1n 1n 10m 20m)
R1 in out 1k
C1 out 0 1u IC=0
.options reltol=1e-8 abstol=1e-12 vntol=1e-10
.control
set noaskquit
set wr_vecnames
set wr_singlescale
tran 10u 5m uic
wrdata rc.dat v(in) v(out)
quit
.endc
.end
